# Ansys Electronics Desktop project, version 2024.2
materials:
  vacuum: permittivity=1
  copper: permeability=0.999991 conductivity=58000000
  air: permittivity=1.0006 permeability=1.0000004

design Maxwell3DDesign1 (Maxwell 3D, Magnetostatic, model units mm)
variables:
  i = 5A
  dist = 50mm
  plateheight = 50
  plate_height = 40mm
geometry:
  Tx [copper] = user_primitive(SegmentedHelix/PolygonHelix.dll, PolygonSegments=0, PolygonRadius=3mm, StartHelixRadius=40mm, RadiusChange=0mm, Pitch=8.01mm, Turns=3, SegmentsPerTurn=36, RightHanded=1)
  Polyline1 = polyline(z=24mm, xy in mm: (40, 0) (40, 10) (200, 10), section circle width=2mm)
  Polyline2 = polyline(z=0mm, xy in mm: (40, 0) (40, -10) (200, -10), section circle width=2mm)
  Region [air] = box(corner=(-140mm, 140mm, -140mm), size=(250mm, -250mm, 280mm))
  Box2 = box(corner=(110mm, -110mm, 140mm), size=(610mm, 250mm, -280mm))
  Tx.unite(Polyline1, Polyline2)
  Tx.subtract(Box2)
  Rx [copper] = user_primitive(SegmentedHelix/PolygonHelix.dll, PolygonSegments=0, PolygonRadius=3mm, StartHelixRadius=40mm, RadiusChange=0mm, Pitch=8.01mm, Turns=3, SegmentsPerTurn=36, RightHanded=1)
  Polyline3 = polyline(z=24mm, xy in mm: (40, 0) (40, 10) (200, 10), section circle width=2mm)
  Polyline4 = polyline(z=0mm, xy in mm: (40, 0) (40, -10) (200, -10), section circle width=2mm)
  Rx.unite(Polyline3, Polyline4)
  Box3 = box(corner=(110mm, -110mm, 140mm), size=(610mm, 250mm, -280mm))
  Rx.subtract(Box3)
  Rx.move(0mm, 0mm, dist)
  Rectangle1 [non-model] = rectangle(corner=(-60mm, -70mm, plate_height), x_size=120mm, y_size=140mm)
boundaries and excitations:
  Tx_out: Current Faces=Tx.face(at (110, 10, 24)) Current=i IsSolid=true Point_out_of_terminal=true
  Tx_in: Current Faces=Tx.face(at (110, -10, 0)) Current=i IsSolid=true Point_out_of_terminal=false
  Rx_out: Current Faces=Rx.face(at (110, 10, 74)) Current=0A IsSolid=true Point_out_of_terminal=true
  Rx_in: Current Faces=Rx.face(at (110, -10, 50)) Current=0A IsSolid=true Point_out_of_terminal=false
parameters:
  Matrix1: Matrix Rx_in, Tx_in: NumberOfTurns=1
mesh:
  Region: LengthBased RefineInside Objects=Region MaxLength=100mm
  Coil: LengthBased Objects=[Rx, Tx] MaxLength=20mm
  initial mesh: GlobalSurfApproximation{CurvedSurfaceApproxChoice=UseSlider SliderMeshSettings=1} GlobalCurvilinear{Apply}
setups:
  Setup1: Magnetostatic MaximumPasses=10 MinimumPasses=2 MinimumConvergedPasses=1 PercentRefinement=30 PercentError=10 RelativeResidual=1e-06 NonLinearResidual=0.001
optimetrics:
  ParametricSetup1: Parametric Sim._Setups=[Setup1]
    sweep dist: LIN 35mm 65mm 5mm
field plots:
  Mag_B1, B_Vector1: B over a plane on Setup1 : LastAdaptive
reports:
  L Table 1: Matrix1.L(Rx_in,Rx_in), Matrix1.L(Tx_in,Rx_in), Matrix1.L(Rx_in,Tx_in), Matrix1.L(Tx_in,Tx_in) vs dist on Setup1 : LastAdaptive
  Coupling Coeff Plot 1: CplCoef(Tx_in,Rx_in) vs dist on Setup1 : LastAdaptive; markers m1 at 40mm, m2 at 45mm, m3 at 50mm, m4 at 55mm

design Simplorer1 (Twin Builder)
variables:
  C_in = 540.2pF
  C_out = 540.2pF
  R_load = 10ohm
components:
  I_in = am()
  V_in = vm()
  E_src = E(Type=ESINE AMPL=320V FREQ=6.78MHz PERIO=0 TPERIO=Tend+1)
  LMatrix1 = MaxwellData(ComponentDataType=MaxwellData name=MaxwellData filename=$PROJECTDIR\WPT.aedt numberofports=4 CouplingDesignName=Maxwell3DDesign1 CouplingSolutionName="Setup1 : LastAdaptive" CouplingMatrixName=Matrix1 CouplingType=SmlInductance3DLink VariationKey="COMPONENT_SCALE='1' dist='50mm' i='5A' plate_height='40mm' plateheight='50'" ModelText="// BEGIN ANSOFT HEADER / // node Rx_in_src Rx_in:src / // node Tx_in_src Tx_in:src / // node Rx_in_snk Rx_in:snk / // node Tx_in_snk Tx_in:snk / // Project: WPT / // Design: Maxwell3DDesign1 / // Format: Simplorer SML / // Topckt: Maxwell3DDesign1 / // Creator: Ansoft Electronics Desktop Student 2024.2.0 / // Date: Mon Jul 07 13:11:41 2025 / // Notes: Scale = 1 / // : Turns/Resistance Rx_in:src = 1/0 / // : Turns/Resistance Tx_in:src = 1/0 / // END ANSOFT HEADER / SMLDEF MaxwellData_16 / { / PORT electrical: Rx_in_src ; / PORT electrical: Tx_in_src ; / PORT electrical: Rx_in_snk ; / PORT electrical: Tx_in_snk ; / MODEL Maxwell3DDesign1_series X1 N_1:=Rx_in_src, N_2:=Tx_in_src, \ / N_3:=Rx_in_snk, N_4:=Tx_in_snk ( ); / SMLDEF Maxwell3DDesign1_series / { / PORT electrical: N_1 ; / PORT electrical: N_2 ; / PORT electrical: N_3 ; / PORT electrical: N_4 ; / INTERN L L1 N1:=N_1, N2:=N_3 ( L:=1.02459885131e-06 ); / INTERN L L2 N1:=N_2, N2:=N_4 ( L:=1.01643012302e-06 ); / INTERN M K1_2 ( L1:=L1.L, L2:=L2.L, K:=0.117065 ); / } // Maxwell3DDesign1_series / } // Maxwell3DDesign1" SolvedVariationKey="Maxwell3DDesign1;Setup1 : LastAdaptive;Matrix1;COMPONENT_S)
  C1 = C(C=C_in)
  C2 = C(C=C_out)
  I_out = am()
  V_out = vm()
  R1 = R(R=R_load)
nets:
  net_10: I_out.1, V_out.0, R1.0
  net_11: LMatrix1.Rx_in_src, V_out.1, R1.1
  net_2: V_in.0, C1.0, I_in.1
  net_5: I_in.0, E_src.1
  net_6: V_in.1, LMatrix1.Tx_in_src, E_src.0
  net_7: C1.1, LMatrix1.1
  net_8: C2.0, LMatrix1.0
  net_9: C2.1, I_out.0
setups:
  AC: LinearFrequencyData(1, 6MHz, 7MHz, 100Hz)
  TR: TransientData(100us, 1ps, 10ps, false, "")
reports:
  XY Plot 1: ((mag(V_out.v)*mag(I_out.i))/(mag(V_in.v)*mag(I_in.i)))*100 vs Freq on AC : AC
  XY Plot 2: I_out.i, V_out.v vs Time on TR : TR
  Data Table 1: V_out.v*I_out.i vs Freq on AC : AC
  Data Table 2: V_out.v*I_out.i vs Time on TR : TR
